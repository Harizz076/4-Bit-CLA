*** 4-bit Positive Edge-Triggered D Flip-flop**
.include "TSMC_180nm.txt"
.global vdd vss

*** Power supplies**
Vdd vdd 0 1.8
Vss vss 0 0

*** PMOS Subcircuit**
.SUBCKT pmos d g s b W=1.8u L=180n
M1 d g s b CMOSP W={W} L={L}
.ENDS pmos

*** NMOS Subcircuit**
.SUBCKT nmos d g s b W=900n L=180n
M1 d g s b CMOSN W={W} L={L}
.ENDS nmos

*** Clock signal generation**
Vclk clk 0 PULSE(0 1.8 0n 100p 100p 5n 10n)
.param time=5n
.param lambda = 0.09u
.param L = 2*lambda
.param Wn = 20*lambda
.param Wp = 10*lambda

*** Input signals**
Vd0 d0 0 PULSE(0 1.8 0n 100p 100p 10n 20n)
Vd1 d1 0 PULSE(0 1.8 0n 100p 100p 25n 50n)
Vd2 d2 0 PULSE(0 1.8 0n 100p 100p 35n 70n)
Vd3 d3 0 PULSE(0 1.8 0n 100p 100p 45n 90n)

.SUBCKT Nswitch gate src drn width=1
M1 drn gate src vss CMOSN W={width} L={L}
+ AS={5*width*L/2} PS={10*L/2+2*width}
+ AD={5*width*L/2} PD={10*L/2+2*width}
.ENDS Nswitch

.SUBCKT Pswitch gate src drn width=1
M2 drn gate src vdd CMOSP W={width} L={L}
+ AS={5*width*L/2} PS={10*L/2+2*width}
+ AD={5*width*L/2} PD={10*L/2+2*width}
.ENDS Pswitch

.subckt inv in out
X1 in vdd out Pswitch width={wp}
X2 in vss out Nswitch width={wn}
.ends

*** Tristate Buffer*
.SUBCKT tristate in en enb out
X1 in vdd n1 Pswitch width={2*Wp}
X2 enb n1 out Pswitch width={2*Wp}
X3 en out n2 Nswitch width={Wn/2}
X4 in vss n2 Nswitch width={Wn/2}
.ENDS tristate

*** D Latch Subcircuit**
.SUBCKT dlatch d clk clk_b q q_b
Xtristate1 d clk clk_b q_b tristate
Xinv1 q_b q inv
Xtristate2 q clk_b clk q_b tristate
.ENDS dlatch

*** Clock Inverter*
Xclk_inv clk clk_b vdd vss inv

*** First D Flip-Flop (DFF1) using Master-Slave Configuration**
*** Master Latch (transparent when clock is LOW)**
Xmaster_latch d0 clk_b clk master_q master_qb dlatch

*** Slave Latch (transparent when clock is HIGH)**
Xslave_latch master_q clk clk_b q0 q0_b dlatch

*** Second D Flip-Flop (DFF2) using Master-Slave Configuration**
*** Master Latch**
Xmaster_latch2 d1 clk_b clk master_q2 master_qb2 dlatch

*** Slave Latch**
Xslave_latch2 master_q2 clk clk_b q1 q1_b dlatch

*** Analysis commands**
.tran 0.1n 100n
.control
run
plot clk d0+2 q0+4 q0_b+6
plot clk d1+2 q1+4 q1_b+6
wrdata output.txt v(clk) v(d0) v(q0) v(d1) v(q1)
.endc

*** Models**
.model nmos nmos level=49
.model pmos pmos level=49
.end
